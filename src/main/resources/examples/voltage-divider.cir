* Voltage divider
* A 10 V supply across two resistors in series.
* The output node sits at R2 / (R1 + R2) of the supply: 6.67 V.
V1 in 0 DC 10
R1 in out 1k
R2 out 0 2k
.op
.end
